# Ansys Electronics Desktop project, version 2022.2
materials:
  Cogent Power - M270-50A, B-H at 50Hz: core_loss_curve{50Hz (0, 0) (0.05, 0.01) (0.1, 0.02) (0.15, 0.045) (0.2, 0.07) (0.25, 0.105) (0.3, 0.14) (0.35, 0.185) (0.4, 0.23) (0.45, 0.28) (0.5, 0.33) (0.55, 0.39) (0.6, 0.45) (0.65, 0.515) (0.7, 0.58) (0.75, 0.655) (0.8, 0.73) (0.85, 0.815) (0.9, 0.9) (0.95, 0.985) (1, 1.07) (1.05, 1.17) (1.1, 1.27) (1.15, 1.385) (1.2, 1.5) (1.25, 1.63) (1.3, 1.76) (1.35, 1.945) (1.4, 2.13) (1.45, 2.325) (1.5, 2.52) (1.55, 2.695) (1.6, 2.87) (1.65, 3) (1.7, 3.13) (1.75, 3.25) (1.8, 3.37)} core_loss_curve{100Hz (0, 0) (0.05, 0.02) (0.1, 0.04) (0.15, 0.105) (0.2, 0.17) (0.25, 0.26) (0.3, 0.35) (0.35, 0.465) (0.4, 0.58) (0.45, 0.715) (0.5, 0.85) (0.55, 1.005) (0.6, 1.16) (0.65, 1.335) (0.7, 1.51) (0.75, 1.705) (0.8, 1.9) (0.85, 2.115) (0.9, 2.33) (0.95, 2.57) (1, 2.81) (1.05, 3.085) (1.1, 3.36) (1.15, 3.67) (1.2, 3.98) (1.25, 4.345) (1.3, 4.71) (1.35, 5.165) (1.4, 5.62) (1.45, 6.155) (1.5, 6.69) (1.55, 7.225) (1.6, 7.76) (1.65, 8.295) (1.7, 8.83) (1.75, 9.365) (1.8, 9.9)} core_loss_curve{200Hz (0, 0) (0.05, 0.05) (0.1, 0.1) (0.15, 0.265) (0.2, 0.43) (0.25, 0.67) (0.3, 0.91) (0.35, 1.21) (0.4, 1.51) (0.45, 1.875) (0.5, 2.24) (0.55, 2.665) (0.6, 3.09) (0.65, 3.58) (0.7, 4.07) (0.75, 4.63) (0.8, 5.19) (0.85, 5.83) (0.9, 6.47) (0.95, 7.205) (1, 7.94) (1.05, 8.775) (1.1, 9.61) (1.15, 10.555) (1.2, 11.5) (1.25, 12.55) (1.3, 13.6) (1.35, 14.95) (1.4, 16.3) (1.45, 17.75) (1.5, 19.2) (1.55, 20.65) (1.6, 22.1) (1.65, 23.55) (1.7, 25) (1.75, 26.45) (1.8, 27.9)} core_loss_curve{400Hz (0, 0) (0.05, 0.145) (0.1, 0.29) (0.15, 0.72) (0.2, 1.15) (0.25, 1.815) (0.3, 2.48) (0.35, 3.325) (0.4, 4.17) (0.45, 5.205) (0.5, 6.24) (0.55, 7.495) (0.6, 8.75) (0.65, 10.225) (0.7, 11.7) (0.75, 13.45) (0.8, 15.2) (0.85, 17.25) (0.9, 19.3) (0.95, 21.7) (1, 24.1) (1.05, 26.9) (1.1, 29.7) (1.15, 32.85) (1.2, 36) (1.25, 39.65) (1.3, 43.3) (1.35, 47.6) (1.4, 51.9) (1.45, 56.9) (1.5, 61.9) (1.55, 66.9) (1.6, 71.9) (1.65, 76.9) (1.7, 81.9) (1.75, 86.9) (1.8, 91.9)} core_loss_curve{1000Hz (0, 0) (0.05, 0.7) (0.1, 1.4) (0.15, 3.205) (0.2, 5.01) (0.25, 7.605) (0.3, 10.2) (0.35, 13.7) (0.4, 17.2) (0.45, 21.65) (0.5, 26.1) (0.55, 31.75) (0.6, 37.4) (0.65, 44.4) (0.7, 51.4) (0.75, 60.05) (0.8, 68.7) (0.85, 79.15) (0.9, 89.6) (0.95, 102.3) (1, 115) (1.05, 130) (1.1, 145) (1.15, 160) (1.2, 175) (1.25, 190) (1.3, 205) (1.35, 220) (1.4, 235) (1.45, 250) (1.5, 265) (1.55, 280) (1.6, 295) (1.65, 310) (1.7, 325) (1.75, 340) (1.8, 355)} permeability{HUnit=A_per_meter BUnit=tesla curve (0, 0) (5, 0.00848205) (10, 0.0186535) (20, 0.0452376) (31.5, 0.1) (42, 0.2) (49.4, 0.3) (56.1, 0.4) (63.1, 0.5) (70.7, 0.6) (79.5, 0.7) (90.1, 0.8) (103, 0.9) (121, 1) (145, 1.1) (185, 1.2) (273, 1.3) (557, 1.4) (1520, 1.5) (3560, 1.6) (6730, 1.7) (11400, 1.8) (20000, 1.89285) (40000, 2.0116) (75000, 2.11928) (130000, 2.21351) (236790, 2.3745) (431300, 2.6336) (785590, 3.0869) (1430900, 3.9022)} conductivity=1818180 core_loss_type="Electrical Steel" core_loss_kh=216.205 core_loss_kc=0.595593 core_loss_ke=2.66671 mass_density=7650
  Cogent Power - M800-100A, B-H at 50Hz: core_loss_curve{50Hz (0, 0) (0.05, 0.025) (0.1, 0.05) (0.15, 0.11) (0.2, 0.17) (0.25, 0.27) (0.3, 0.37) (0.35, 0.495) (0.4, 0.62) (0.45, 0.77) (0.5, 0.92) (0.55, 1.095) (0.6, 1.27) (0.65, 1.485) (0.7, 1.7) (0.75, 1.94) (0.8, 2.18) (0.85, 2.46) (0.9, 2.74) (0.95, 3.035) (1, 3.33) (1.05, 3.665) (1.1, 4) (1.15, 4.365) (1.2, 4.73) (1.25, 5.1) (1.3, 5.47) (1.35, 5.875) (1.4, 6.28) (1.45, 6.74) (1.5, 7.2) (1.55, 7.71) (1.6, 8.22) (1.65, 8.67) (1.7, 9.12) (1.75, 9.59) (1.8, 10.06)} permeability{HUnit=A_per_meter BUnit=tesla curve (0, 0) (5, 0.0043981) (10, 0.00904752) (20, 0.0201056) (30, 0.0350591) (40, 0.0653432) (49.3, 0.1) (69.2, 0.2) (85.1, 0.3) (101, 0.4) (117, 0.5) (135, 0.6) (154, 0.7) (174, 0.8) (196, 0.9) (221, 1) (261, 1.1) (332, 1.2) (450, 1.3) (675, 1.4) (1190, 1.5) (2550, 1.6) (5360, 1.7) (9770, 1.8) (12000, 1.82659) (20000, 1.90236) (40000, 2.00517) (80000, 2.10798) (128000, 2.16813)} conductivity=2564100 mass_density=7650
  Cogent Power - M400-50A, B-H at 50Hz: core_loss_curve{50Hz (0, 0) (0.05, 0.01) (0.1, 0.02) (0.15, 0.055) (0.2, 0.09) (0.25, 0.14) (0.3, 0.19) (0.35, 0.25) (0.4, 0.31) (0.45, 0.385) (0.5, 0.46) (0.55, 0.54) (0.6, 0.62) (0.65, 0.715) (0.7, 0.81) (0.75, 0.91) (0.8, 1.01) (0.85, 1.125) (0.9, 1.24) (0.95, 1.365) (1, 1.49) (1.05, 1.625) (1.1, 1.76) (1.15, 1.925) (1.2, 2.09) (1.25, 2.275) (1.3, 2.46) (1.35, 2.71) (1.4, 2.96) (1.45, 3.265) (1.5, 3.57) (1.55, 3.975) (1.6, 4.38) (1.65, 4.7) (1.7, 5.02) (1.75, 5.245) (1.8, 5.47)} core_loss_curve{100Hz (0, 0) (0.05, 0.035) (0.1, 0.07) (0.15, 0.165) (0.2, 0.26) (0.25, 0.4) (0.3, 0.54) (0.35, 0.71) (0.4, 0.88) (0.45, 1.075) (0.5, 1.27) (0.55, 1.5) (0.6, 1.73) (0.65, 1.985) (0.7, 2.24) (0.75, 2.52) (0.8, 2.8) (0.85, 3.12) (0.9, 3.44) (0.95, 3.795) (1, 4.15) (1.05, 4.55) (1.1, 4.95) (1.15, 5.4) (1.2, 5.85) (1.25, 6.365) (1.3, 6.88) (1.35, 7.53) (1.4, 8.18) (1.45, 9) (1.5, 9.82) (1.55, 10.64) (1.6, 11.46) (1.65, 12.28) (1.7, 13.1) (1.75, 13.92) (1.8, 14.74)} core_loss_curve{200Hz (0, 0) (0.05, 0.08) (0.1, 0.16) (0.15, 0.4) (0.2, 0.64) (0.25, 0.995) (0.3, 1.35) (0.35, 1.8) (0.4, 2.25) (0.45, 2.79) (0.5, 3.33) (0.55, 3.955) (0.6, 4.58) (0.65, 5.305) (0.7, 6.03) (0.75, 6.855) (0.8, 7.68) (0.85, 8.63) (0.9, 9.58) (0.95, 10.64) (1, 11.7) (1.05, 12.95) (1.1, 14.2) (1.15, 15.6) (1.2, 17) (1.25, 18.6) (1.3, 20.2) (1.35, 22) (1.4, 23.8) (1.45, 26.05) (1.5, 28.3) (1.55, 30.55) (1.6, 32.8) (1.65, 35.05) (1.7, 37.3) (1.75, 39.55) (1.8, 41.8)} core_loss_curve{400Hz (0, 0) (0.05, 0.24) (0.1, 0.48) (0.15, 1.14) (0.2, 1.8) (0.25, 2.785) (0.3, 3.77) (0.35, 5.03) (0.4, 6.29) (0.45, 7.83) (0.5, 9.37) (0.55, 11.285) (0.6, 13.2) (0.65, 15.35) (0.7, 17.5) (0.75, 20.1) (0.8, 22.7) (0.85, 25.75) (0.9, 28.8) (0.95, 32.35) (1, 35.9) (1.05, 40.05) (1.1, 44.2) (1.15, 49) (1.2, 53.8) (1.25, 59.35) (1.3, 64.9) (1.35, 71.15) (1.4, 77.4) (1.45, 84.55) (1.5, 91.7) (1.55, 98.85) (1.6, 106) (1.65, 113.15) (1.7, 120.3) (1.75, 127.45) (1.8, 134.6)} core_loss_curve{1000Hz (0, 0) (0.05, 1.06) (0.1, 2.12) (0.15, 4.805) (0.2, 7.49) (0.25, 11.395) (0.3, 15.3) (0.35, 20.5) (0.4, 25.7) (0.45, 32.35) (0.5, 39) (0.55, 47.55) (0.6, 56.1) (0.65, 66.6) (0.7, 77.1) (0.75, 90.1) (0.8, 103.1) (0.85, 119.05) (0.9, 135) (0.95, 154.65) (1, 174.3) (1.05, 196.55) (1.1, 218.8) (1.15, 245.6) (1.2, 272.4) (1.25, 303.5) (1.3, 334.6) (1.35, 370.1) (1.4, 405.6) (1.45, 447) (1.5, 488.4) (1.55, 529.8) (1.6, 571.2) (1.65, 612.6) (1.7, 654) (1.75, 695.4) (1.8, 736.8)} permeability{HUnit=A_per_meter BUnit=tesla curve (0, 0) (5, 0.0081679) (10, 0.0174667) (20, 0.044735) (25, 0.06283) (32.6, 0.1) (43.5, 0.2) (50.8, 0.3) (57.2, 0.4) (63.4, 0.5) (69.9, 0.6) (77.3, 0.7) (86, 0.8) (97.2, 0.9) (113.2, 1) (137.8, 1.1) (180.2, 1.2) (269.5, 1.3) (516.8, 1.4) (1307, 1.5) (3180, 1.6) (6361, 1.7) (10890, 1.79526) (20000, 1.8935) (40000, 2.00551) (80000, 2.11752) (120000, 2.18304) (140000, 2.20795)} conductivity=2380950 core_loss_type="Electrical Steel" core_loss_kh=192.421 core_loss_kc=1.44371 mass_density=7650

design RMxprtDesign1 (RMxprt, Three Phase Synchronous Machine, model units mm)
variables:
  Do = 6858mm
  Dr = 6114.8mm
  airgap = 28.7mm
  Di = Dr+2*airgap
  Ls = 1870.1mm
  h0 = 1mm
  h1 = 3mm
  h2 = 101.5mm
  b1 = b2+4mm
  b2 = 22.7mm
  wireWidth = 7.93mm
  wireHeight = 1.7175mm
  Ds = Dr-1161.6mm
  Lr = Ls
  poleBodyWidth = 343mm
  poleBodyHeight = 252mm
  poleShoeWidth = 406mm
  poleShoeHeight = 45mm
  Nf = 41
  fieldWireWidth = 50mm
  fieldWireHeight = 5mm
  apparentPower = sqrt(3)*13800*1860/1e3
  ratedVoltage = 13800V
  ratedSpeed = 187.5rpm
  opTemperature = 75cel
  strands = 38
  outDia = 6800mm
machine:
  Machine: FrictionLoss=300kW WindLoss=0W ReferenceSpeed=187.5rpm NumberOfPoles=32
  Stator: SkewWidth=0 NumberOfSlots=255 LaminationSectors=0 PressBoardThickness=0mm OuterDiameter=Do InnerDiameter=Di Length=Ls StackingFactor=0.95 SteelType="Cogent Power - M270-50A, B-H at 50Hz" SlotType=6
  Rotor: OuterDiameter=Dr InnerDiameter=Ds Length=Lr SteelType="Cogent Power - M800-100A, B-H at 50Hz" SecondAirGap=0mm PoleBodyHeight=poleBodyHeight PoleShoeHeight=poleShoeHeight Off2x=0mm Off2y=0mm PoleArcOffset=0mm PoleBodyWidth=poleBodyWidth PoleShoeWidth=poleShoeWidth PoleStackingFactor=0.97 PoleSteelType="Cogent Power - M400-50A, B-H at 50Hz" PressBoardThickness=0mm StackingFactor=0.95 ShoeInsulation=0mm PoleInsulation=0mm WindingClearance=0mm
  Shaft:
  Stator Slot: Hs0=h0 Hs1=h1 Hs2=h2 Bs0=0mm Bs1=b1 Bs2=b2 Rs=0mm ToothWidth=0mm
  Stator Winding: WindingType=Whole-Coiled WindingLayers=2 ParallelBranches=1 ConductorsPerSlot=2 CoilPitch=7 EndAdjustment=0mm BaseInnerRadius=0mm TipInnerDiameter=0mm EndClearance=0mm CoilWrap=0mm SlotLiner=0mm WedgeThickness=0mm LayerInsulation=0mm BottomInsulation=0mm LimitedFillFactor=0.75 WdgNumberofPriodicMultipler=1 NumberOfStrands=38 WireWrap=0mm InterturnInsulation=0mm WireDiameter=0mm WireWidth=wireWidth WireThickness=wireHeight Gauge=STANDARDRECT
  Rotor Winding: WindingType=EdgewiseCoil ParallelBranches=1 ConductorsPerPole=2*Nf AxialClearance=0mm LimitedCrossWidth=0mm LimitedCrossHeight=0mm NumberOfStrands=1 WireWrap=0mm InterturnInsulation=0mm WireDiameter=0mm WireWidth=fieldWireWidth WireThickness=fieldWireHeight Gauge=STANDARDRECT WindingFillet=0mm
setups:
  Setup1: SYNM Generator RatedOutputPower=apparentPower RatedVoltage=ratedVoltage RatedSpeed=ratedSpeed OperatingTemperature=opTemperature LoadType=InfiniteBus RatedPowerFactor=0.9 ExciterEfficiency=100 StartingFieldResistance=0ohm
reports:
  Efficiency: EfficiencyParameter vs Do on Setup1 : Performance
  Mass: ArmatureCopperWeightParameter, ArmatureCoreSteelWeightParameter vs Do on Setup1 : Performance
  SCR: DAxisReactanceX1PlusXadParameter vs Do on Setup1 : Performance
  Losses: ArmatureCopperLossParameter, FieldCopperLossParameter, IronCoreLossParameter vs Do on Setup1 : Performance
  Current Table 1: ExcitingCurrentParameter, ExcitingCurrentatPFeq0Parameter vs Do on Setup1 : Performance
